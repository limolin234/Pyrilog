* generated by Pyrilog 1.1.0
V1 n1 0 0.10000000000000001
E1 n2 0 n1 0 3
Nnonlinear_amplifier_1 n3 0 n1 0 m_nonlinear_amplifier_1
.model m_nonlinear_amplifier_1 nonlinearamplifier_87c962b7890b gain=2 cubic=10
Nnonlinear_charge_1 n1 0 m_nonlinear_charge_1
.model m_nonlinear_charge_1 nonlinearcharge_5c907fa19990 capacitance=9.9999999999999998e-13 nonlinear_capacitance=1e-13
R1 n2 0 1000
R2 n3 0 1000

.end
