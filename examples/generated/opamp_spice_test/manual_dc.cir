* generated by Pyrilog 1.1.0
V1 n1 0 5
V2 n2 0 -5
V3 n8 0 0
R1 0 n3 10000
R2 0 n4 10000
I1 n5 n2 0.00020000000000000001
Nn_p_n_manual_1 n3 n8 n5 m_n_p_n_manual_1
.model m_n_p_n_manual_1 npnmanual_393d6d72fb1e saturation_current=1e-14 forward_beta=100
Nn_p_n_manual_2 n4 n7 n5 m_n_p_n_manual_2
.model m_n_p_n_manual_2 npnmanual_393d6d72fb1e saturation_current=1e-14 forward_beta=100
Nn_p_n_manual_3 n7 n3 n6 m_n_p_n_manual_3
.model m_n_p_n_manual_3 npnmanual_393d6d72fb1e saturation_current=1e-14 forward_beta=1000
R3 n6 n2 1000
R4 n1 n7 1272

* Manual stimulus and result export; not emitted by the compiler.
.control
pre_osdi /media/limolin/68A318E6744DCB0F/Users/李墨林/Documents/MyProjects/behavior_leval_simulation/pyrilog/examples/generated/opamp_spice_test/verilog_a/npnmanual_393d6d72fb1e.osdi
dc V3 -0.2 0.2 0.002
set filetype=ascii
write dc.raw v(n8) v(n7)
quit
.endc
.end
